# Ansys Electronics Desktop project, version 2022.2
materials:
  vacuum: permittivity=1
  copper: permeability=0.999991 conductivity=58000000
  FR4_epoxy: permittivity=3.74076+0.0255671*ln((2.53303e+22+Freq*Freq)/(4.95658e+09+Freq*Freq)) conductivity=1e-12+2.84472e-12*Freq*(atan(Freq/70403)-atan(Freq/1.59155e+11))
  FR4_new_paper: permittivity=3.74076+0.0255671*ln((2.53303e+22+Freq*Freq)/(4.95658e+09+Freq*Freq)) conductivity=1e-12+2.84472e-12*Freq*(atan(Freq/70403)-atan(Freq/1.59155e+11))
  FR4_freq_dep: permittivity=3.74076+0.0255671*ln((2.53303e+22+Freq*Freq)/(4.95658e+09+Freq*Freq)) conductivity=1e-12+2.84472e-12*Freq*(atan(Freq/70403)-atan(Freq/1.59155e+11))

design HFSSDesign1 (HFSS, DrivenTerminal, model units mm)
options: Allow_Material_Override Calculate_Lossy_Dielectrics
variables:
  rvia = 5mil
  apad = 5mil
  bantipad = 15mil
  tgnd = 1mil
  hudie = 12mil
  dk = 3.5
geometry:
  bot [copper] = box(corner=(-1000mil, -1000mil, 0mil), size=(2000mil, 2000mil, tgnd))
  via = cylinder(axis=Z, base_centre=(0mm, 0mm, 0mm), radius=rvia, height=tgnd*2+hudie)
  top [copper] = bot.duplicate_along_line(step=(0mm, 0mm, tgnd+hudie), total=2)
  Cylinder1 = cylinder(axis=Z, base_centre=(0mm, 0mm, tgnd+hudie), radius=bantipad, height=tgnd)
  Cylinder1_1 = Cylinder1.duplicate_along_line(step=(0mm, 0mm, -tgnd-hudie), total=2)
  Cylinder1_2 = Cylinder1.copy()
  Cylinder1.delete()
  top.subtract(Cylinder1_2)
  bot.subtract(Cylinder1_1)
  die [FR4_freq_dep] = box(corner=(-1000mil, -1000mil, 0), size=(2000mil, 2000mil, hudie+tgnd*2))
  Region [vacuum] = region(percentage_offset=0 on all sides)
  bot_1 = bot.copy()
  top_1 = top.copy()
  via_1 = via.copy()
  die.subtract(bot_1, top_1, via_1)
  via.move_faces(MoveAlongNormalFlag=true OffsetDistance=1mm FacesToMove=via.face(3 of 3))
  die.move_faces(MoveAlongNormalFlag=true OffsetDistance=1mm FacesToMove=die.face(+z))
  top.move_faces(MoveAlongNormalFlag=true OffsetDistance=1mm FacesToMove=top.face(1 of 6))
  via.move_faces(MoveAlongNormalFlag=true OffsetDistance=1mm FacesToMove=via.face(2 of 3))
  die.move_faces(MoveAlongNormalFlag=true OffsetDistance=1mm FacesToMove=die.face(-z))
  bot.move_faces(MoveAlongNormalFlag=true OffsetDistance=1mm FacesToMove=bot.face(-z))
  str [copper] = box(corner=(-rvia, 0, tgnd+hudie/2-tgnd/2), size=(rvia*2, 1000mil, tgnd))
  str_1 = str.copy()
  die.subtract(str_1)
  Rectangle3 = rectangle(corner=(-50mil, 1000mil, 0mm), z_size=hudie+tgnd*2, x_size=100mil)
  Box1 = box(corner=(-1000mil, -1000mil, 0mm), size=(2000mil, 1000mil+bantipad, tgnd*2+hudie))
  via.move_faces(MoveAlongNormalFlag=true OffsetDistance=-1mm FacesToMove=via.face(3 of 3))
  die.move_faces(MoveAlongNormalFlag=true OffsetDistance=-1mm FacesToMove=die.face(+z))
  top.move_faces(MoveAlongNormalFlag=true OffsetDistance=-1mm FacesToMove=top.face(1 of 6))
  via.move_faces(MoveAlongNormalFlag=true OffsetDistance=-1mm FacesToMove=via.face(2 of 3))
  via.delete()
  die.move_faces(MoveAlongNormalFlag=true OffsetDistance=-1mm FacesToMove=die.face(-z))
  bot.move_faces(MoveAlongNormalFlag=true OffsetDistance=-1mm FacesToMove=bot.face(-z))
  Box1_1 = Box1.copy()
  bot.subtract(Box1_1)
  Box1_2 = Box1.copy()
  die.subtract(Box1_2)
  Box1_3 = Box1.copy()
  str.subtract(Box1_3)
  Box1_4 = Box1.copy()
  top.subtract(Box1_4)
  Box1.delete()
  Rectangle3_1 = Rectangle3.duplicate_along_line(step=(0mm, -1000mil+bantipad, 0mm), total=2)
  Rectangle4 = rectangle(corner=(0mm, 15mil, 0mm), y_size=985mil, z_size=tgnd*2+hudie)
boundaries and excitations:
  Rad1: Radiation Objects=Region
  str_T1: Terminal port=1 Faces=str.face(+y) TerminalResistance=50ohm
  str_T2: Terminal port=2 Faces=str.face(at (0, 0.381, 0.1778)) TerminalResistance=50ohm
  1: Wave Port Faces=Rectangle3.face(at (0, 25.4, 0.1778)) NumModes=1 DeembedDist=392.5mil
  2: Wave Port Faces=Rectangle3_1.face NumModes=1 DeembedDist=392.5mil
  reference conductors: bot, top
setups:
  Setup1: HfssDriven Frequency=60GHz MaxDeltaS=0.002 MaximumPasses=50 MinimumPasses=10 MinimumConvergedPasses=5 PercentRefinement=30 BasisOrder=1 PortAccuracy=2 DrivenSolverType="Direct Solver"
    sweep Sweep: 40MHz to 60000MHz step 0.04GHz; Type=Interpolating InterpTolerance=0.5 InterpMaxSolns=250 PassivityErrorTolerance=0.0001
source amplitudes:
  1:1: 1V 0deg
  2:1: 0V 0deg
field plots:
  Vector_E1: E Field over Rectangle4.face on Setup1 : LastAdaptive at Freq=60GHz Phase=0deg
reports:
  Terminal S Parameter Plot 1: dB(St(str_T1,str_T1)) vs Freq on Setup1 : Sweep
  Terminal S Parameter Plot 2: dB(St(str_T2,str_T1)) vs Freq on Setup1 : Sweep
