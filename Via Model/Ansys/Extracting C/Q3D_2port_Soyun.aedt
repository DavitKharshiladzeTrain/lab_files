# Ansys Electronics Desktop project, version 2022.2
materials:
  vacuum: permittivity=1
  copper: permeability=0.999991 conductivity=58000000
  FR4_epoxy_paper: permittivity=3.43092+0.0235024*ln((4.0062e+22+Freq*Freq)/(8.37362e+09+Freq*Freq)) conductivity=1e-12+2.61499e-12*Freq*(atan(Freq/91507.5)-atan(Freq/2.00155e+11))

design PMC (HFSS, DrivenTerminal, model units mil)
variables:
  hcavity = 15.3mil
  tlayer = 1.3mil
  L = 1600mil
geometry:
  via [copper] = cylinder(axis=Z, base_centre=(0mil, 0mil, 0mil), radius=4mil, height=tlayer+hcavity+tlayer)
  via_1 = via.copy()
  via_5 = via.copy()
  via.move_faces(MoveAlongNormalFlag=true OffsetDistance=39.370079mil FacesToMove=via.face(3 of 3))
  via.move_faces(MoveAlongNormalFlag=true OffsetDistance=39.370079mil FacesToMove=via.face(2 of 3))
  coordinate_system RelativeCS1 = origin=(31.496063mil, 0mil, -94.488189mil) x=(39.370079mil, 0mil, 0mil) y=(0mil, 39.370079mil, 0mil)
  via.move_faces(MoveAlongNormalFlag=true OffsetDistance=-39.370079mil FacesToMove=via.face(3 of 3)) in RelativeCS1
  via.move_faces(MoveAlongNormalFlag=true OffsetDistance=-39.370079mil FacesToMove=via.face(2 of 3)) in RelativeCS1
  top = box(corner=(-L/2, -L/2, 0mil), size=(L, L, tlayer))
  bottom [copper] = top.duplicate_along_line(step=(0mil, 0mil, -17.9mil), total=2)
  top.delete()
  antipad = cylinder(axis=Z, base_centre=(0mil, 0mil, 0mil), radius=15mil, height=tlayer+hcavity+tlayer)
  antipad_2 = antipad.copy()
  bottom.subtract(antipad_2)
  bottom.move(0mil, 0mil, 35.8mil)
  bottom.move(0mil, 0mil, -1.3mil)
  antipad.subtract(via_1)
  antipad_4 = antipad.copy()
  bottom.subtract(antipad_4)
  antipad.delete()
  bottom.subtract(via_5)
  bottom.move_faces(MoveAlongNormalFlag=true OffsetDistance=39.370079mil FacesToMove=bottom.face(#84))
  bottom.move_faces(MoveAlongNormalFlag=true OffsetDistance=-39.370079mil FacesToMove=bottom.face(#84)) in RelativeCS1
  antipad1 [FR4_epoxy_paper] = cylinder(axis=Z, base_centre=(0mil, 0mil, 0mil), radius=15mil, height=tlayer+hcavity+tlayer)
  via1 = cylinder(axis=Z, base_centre=(0mil, 0mil, 0mil), radius=4mil, height=tlayer+hcavity+tlayer)
  via_6 = via1.copy()
  antipad1.subtract(via_6)
  antipad_3 = antipad1.copy()
  via_2 = via1.copy()
  via_3 = via1.copy()
  antipad1.subtract(via_3)
  antipad1.move_faces(MoveAlongNormalFlag=true OffsetDistance=39.370079mil FacesToMove=antipad1.face(3 of 3))
  antipad1.move_faces(MoveAlongNormalFlag=true OffsetDistance=39.370079mil FacesToMove=antipad1.face(2 of 3))
  coordinate_system RelativeCS2 = origin=(31.496063mil, 0mil, -94.488189mil) x=(39.370079mil, 0mil, 0mil) y=(0mil, 39.370079mil, 0mil)
  antipad1.move_faces(MoveAlongNormalFlag=true OffsetDistance=-39.370079mil FacesToMove=antipad1.face(3 of 3)) in RelativeCS2
  antipad1.move_faces(MoveAlongNormalFlag=true OffsetDistance=-39.370079mil FacesToMove=antipad1.face(2 of 3)) in RelativeCS2
  dielectric [FR4_epoxy_paper] = box(corner=(-L/2, -L/2, tlayer), size=(L, L, hcavity))
  dielectric.subtract(via_2)
  dielectric.subtract(antipad_3)
  via_4 = via1.copy()
  dielectric.subtract(via_4)
  via1.delete()
  antipad1.move_faces(MoveAlongNormalFlag=true OffsetDistance=-1.3mil FacesToMove=antipad1.face(2 of 3))
  via.move_faces(MoveAlongNormalFlag=true OffsetDistance=-1.3mil FacesToMove=via.face(2 of 3))
  bottom.move_faces(MoveAlongNormalFlag=true OffsetDistance=1mm FacesToMove=bottom.face(#84))
  antipad1.move_faces(MoveAlongNormalFlag=true OffsetDistance=1mm FacesToMove=antipad1.face(3 of 3))
  via.move_faces(MoveAlongNormalFlag=true OffsetDistance=1mm FacesToMove=via.face(3 of 3))
  Rectangle1 = rectangle(corner=(0mil, 0mil, 57.270079mil), x_size=20mil, y_size=20mil)
  Rectangle1_1, Rectangle1_2, Rectangle1_3 = Rectangle1.duplicate_around_axis(axis=Z, angle=90deg, total=4)
  Rectangle1.unite(Rectangle1_1, Rectangle1_2, Rectangle1_3)
  dielectric.move_faces(MoveAlongNormalFlag=true OffsetDistance="(-15.3/2) mil" FacesToMove=dielectric.face(-z))
  antipad1.move_faces(MoveAlongNormalFlag=true OffsetDistance="(-15.3/2) mil" FacesToMove=antipad1.face(2 of 3))
  via.move_faces(MoveAlongNormalFlag=true OffsetDistance="(-15.3/2) mil" FacesToMove=via.face(2 of 3))
  dielectric.move_faces(MoveAlongNormalFlag=true OffsetDistance="(15.3/2) mil" FacesToMove=dielectric.face(-z))
  antipad1.move_faces(MoveAlongNormalFlag=true OffsetDistance="(15.3/2) mil" FacesToMove=antipad1.face(2 of 3))
  via.move_faces(MoveAlongNormalFlag=true OffsetDistance="(15.3/2) mil" FacesToMove=via.face(2 of 3))
  dielectric.move_faces(MoveAlongNormalFlag=true OffsetDistance="(-15.3/2) mil" FacesToMove=dielectric.face(-z))
  antipad1.move_faces(MoveAlongNormalFlag=true OffsetDistance="(-15.3/2) mil" FacesToMove=antipad1.face(2 of 3))
  via.move_faces(MoveAlongNormalFlag=true OffsetDistance="(-15.3/2) mil" FacesToMove=via.face(2 of 3))
  dielectric.move_faces(MoveAlongNormalFlag=true OffsetDistance="(15.3/2) mil" FacesToMove=dielectric.face(-z))
  antipad1.move_faces(MoveAlongNormalFlag=true OffsetDistance="(15.3/2) mil" FacesToMove=antipad1.face(2 of 3))
  via.move_faces(MoveAlongNormalFlag=true OffsetDistance="(15.3/2) mil" FacesToMove=via.face(2 of 3))
  dielectric.move_faces(MoveAlongNormalFlag=true OffsetDistance="(-15.3/2) mil" FacesToMove=dielectric.face(-z))
  antipad1.move_faces(MoveAlongNormalFlag=true OffsetDistance="(-15.3/2) mil" FacesToMove=antipad1.face(2 of 3))
  via.move_faces(MoveAlongNormalFlag=true OffsetDistance="(-15.3/2) mil" FacesToMove=via.face(2 of 3))
  Region [vacuum] = region(+X=0 percentage offset, -X=0 percentage offset, +Y=0 percentage offset, -Y=0 percentage offset, +Z=0 percentage offset, -Z=200mil absolute offset)
  dielectric.move_faces(MoveAlongNormalFlag=true OffsetDistance="(15.3/2) mil" FacesToMove=dielectric.face(-z))
  antipad1.move_faces(MoveAlongNormalFlag=true OffsetDistance="(15.3/2) mil" FacesToMove=antipad1.face(2 of 3))
  via.move_faces(MoveAlongNormalFlag=true OffsetDistance="(15.3/2) mil" FacesToMove=via.face(2 of 3))
  dielectric.move_faces(MoveAlongNormalFlag=true OffsetDistance="(-15.3/2) mil" FacesToMove=dielectric.face(-z))
  antipad1.move_faces(MoveAlongNormalFlag=true OffsetDistance="(-15.3/2) mil" FacesToMove=antipad1.face(2 of 3))
  via.move_faces(MoveAlongNormalFlag=true OffsetDistance="(-15.3/2) mil" FacesToMove=via.face(2 of 3))
  dielectric.move_faces(MoveAlongNormalFlag=true OffsetDistance="(15.3/2) mil" FacesToMove=dielectric.face(-z))
  antipad1.move_faces(MoveAlongNormalFlag=true OffsetDistance="(15.3/2) mil" FacesToMove=antipad1.face(2 of 3))
  via.move_faces(MoveAlongNormalFlag=true OffsetDistance="(15.3/2) mil" FacesToMove=via.face(2 of 3))
  dielectric.move_faces(MoveAlongNormalFlag=true OffsetDistance="(-15.3/2) mil" FacesToMove=dielectric.face(-z))
  antipad1.move_faces(MoveAlongNormalFlag=true OffsetDistance="(-15.3/2) mil" FacesToMove=antipad1.face(2 of 3))
  via.move_faces(MoveAlongNormalFlag=true OffsetDistance="(-15.3/2) mil" FacesToMove=via.face(2 of 3))
boundaries and excitations:
  PerfH1: Perfect H Faces=dielectric.face(-z)
  Rad1: Radiation Objects=Region
  via_T1: Terminal port=1 Faces=via.face(3 of 3) TerminalResistance=50ohm
  1: Wave Port Faces=Rectangle1.face(at (10, 10, 57.2701)) NumModes=1 DeembedDist=1mm
  reference conductors: bottom
setups:
  setup: HfssDriven MultipleAdaptiveFreqsSetup{AdaptAt{Frequency=2.5GHz Delta=0.01} AdaptAt{Frequency=5GHz Delta=0.01} AdaptAt{Frequency=10GHz Delta=0.01} AdaptAt{Frequency=50GHz Delta=0.01} AdaptAt{Frequency=80GHz Delta=0.01}} MaximumPasses=20 MinimumPasses=1 MinimumConvergedPasses=1 PercentRefinement=30 BasisOrder=1 PortAccuracy=2 DrivenSolverType="Direct Solver"
    sweep Sweep1: 40MHz to 100GHz step 40MHz; Type=Interpolating InterpTolerance=0.5 InterpMaxSolns=50 PassivityErrorTolerance=0.0001
source amplitudes:
  1:1: 1V 0deg
reports:
   Plot 3: -1/(2*pi*freq*(im(Zt(via_T1,via_T1)) - 132 * 2 * pi * freq)) vs Freq on setup : Sweep1
   Plot 4: (1 -  132/im(Zt(via_T1,via_T1)) ) * (1/(4*pi*pi*freq*freq*132)) vs Freq on setup : Sweep1; markers m1 at 0.084579575GHz
   Plot 5: dB10(Zt(via_T1,via_T1)) vs Freq on setup : Sweep1
   Plot 6: 1/(re(Zo(1))*2*pi*freq) vs Freq on setup : Sweep1
   Plot 7_1: -1/(im(Zt(via_T1,via_T1))*2*pi*freq) vs Freq on setup : Sweep1

design Q3DDesign1 (Q3D Extractor, model units mil)
options: SParamCalcMethod=EqTransLine Calculate_Lossy_Dielectrics
variables:
  L = 1600mil
  hcavity = 15.3mil
  tlayer = 1.3mil
geometry:
  via [copper] = cylinder(axis=Z, base_centre=(0mil, 0mil, 0mil), radius=4mil, height=tlayer+hcavity+tlayer)
  top [copper] = box(corner=(-L/2, -L/2, 0mil), size=(L, L, tlayer))
  bottom [copper] = top.duplicate_along_line(step=(0mil, 0mil, -17.9mil), total=2)
  antipad [FR4_epoxy_paper] = cylinder(axis=Z, base_centre=(0mil, 0mil, 0mil), radius=15mil, height=tlayer+hcavity+tlayer)
  dielectric [FR4_epoxy_paper] = box(corner=(-L/2, -L/2, tlayer), size=(L, L, hcavity))
  antipad_1 = antipad.copy()
  top.subtract(antipad_1)
  antipad_2 = antipad.copy()
  bottom.subtract(antipad_2)
  via_1 = via.copy()
  antipad.subtract(via_1)
  via_2 = via.copy()
  dielectric.subtract(via_2)
  antipad_3 = antipad.copy()
  dielectric.subtract(antipad_3)
  bottom.move(0mil, 0mil, 35.8mil)
  bottom.move(0mil, 0mil, -1.3mil)
  antipad_4 = antipad.copy()
  bottom.subtract(antipad_4)
  antipad_5 = antipad.copy()
  top.subtract(antipad_5)
  via_3 = via.copy()
  antipad.subtract(via_3)
  via_4 = via.copy()
  dielectric.subtract(via_4)
  via_5 = via.copy()
  bottom.subtract(via_5)
  via.move_faces(MoveAlongNormalFlag=true OffsetDistance=39.370079mil FacesToMove=via.face(3 of 3))
  antipad.move_faces(MoveAlongNormalFlag=true OffsetDistance=39.370079mil FacesToMove=antipad.face(3 of 3))
  bottom.move_faces(MoveAlongNormalFlag=true OffsetDistance=39.370079mil FacesToMove=bottom.face(#280))
  antipad.move_faces(MoveAlongNormalFlag=true OffsetDistance=39.370079mil FacesToMove=antipad.face(2 of 3))
  via.move_faces(MoveAlongNormalFlag=true OffsetDistance=39.370079mil FacesToMove=via.face(2 of 3))
  top.move_faces(MoveAlongNormalFlag=true OffsetDistance=39.370079mil FacesToMove=top.face(-z))
  Region [vacuum] = region(percentage_offset=0 on all sides)
  coordinate_system RelativeCS1 = origin=(31.496063mil, 0mil, -94.488189mil) x=(39.370079mil, 0mil, 0mil) y=(0mil, 39.370079mil, 0mil)
  antipad.move_faces(MoveAlongNormalFlag=true OffsetDistance=-39.370079mil FacesToMove=antipad.face(3 of 3)) in RelativeCS1
  via.move_faces(MoveAlongNormalFlag=true OffsetDistance=-39.370079mil FacesToMove=via.face(3 of 3)) in RelativeCS1
  bottom.move_faces(MoveAlongNormalFlag=true OffsetDistance=-39.370079mil FacesToMove=bottom.face(#280)) in RelativeCS1
  via.move_faces(MoveAlongNormalFlag=true OffsetDistance=-39.370079mil FacesToMove=via.face(2 of 3)) in RelativeCS1
  antipad.move_faces(MoveAlongNormalFlag=true OffsetDistance=-39.370079mil FacesToMove=antipad.face(2 of 3)) in RelativeCS1
  top.move_faces(MoveAlongNormalFlag=true OffsetDistance=-39.370079mil FacesToMove=top.face(-z)) in RelativeCS1
boundaries and excitations:
  Source1: Source Faces=via.face(3 of 3) TerminalType=ConstantVoltage Net=via
  bottom: SignalNet Objects=bottom
  top: SignalNet Objects=top
  via: SignalNet Objects=via
  Sink1: Sink Faces=via.face(2 of 3) TerminalType=ConstantVoltage Net=via
setups:
  Setup1: Matrix AdaptiveFreq=60GHz Cap{MaxPass=10 MinPass=1 MinConvPass=1 PerError=1 PerRefine=30 AutoIncreaseSolutionOrder SolutionOrder=High Solver_Type=Iterative} DC{Cond{MaxPass=10 MinPass=1 MinConvPass=1 PerError=1 PerRefine=30} Mult{MaxPass=1 MinPass=1 MinConvPass=1 PerError=1 PerRefine=30} Solution_Order=Normal} AC{MaxPass=10 MinPass=1 MinConvPass=1 PerError=1 PerRefine=30} ErrorValue=0.1
    sweep Sweep1: 0GHz to 40MHz step 1MHz; 40MHz to 200GHz step 40MHz; Type=Interpolating InterpTolerance=0.5 InterpMaxSolns=50 MinSolvedFreq=100000
source amplitudes:
  via:Source1: AC 1A
  bottom, top: Cap 0V 0deg
  via: Cap 1V 0deg
  via:Source1: DC 1A
reports:
  C Matrix Plot 1: C(top,bottom) vs Freq on Setup1 : Sweep1
  C Matrix Plot 2: -C(via,bottom)/2 vs Freq on Setup1 : Sweep1; markers m1 at 40.12GHz, m2 at 0GHz
   Plot 1: -C(via,bottom) vs Freq on Setup1 : Sweep1
  C Matrix Plot 3: -(C(via,bottom) + C(via,top) + C(via,via)) vs Freq on Setup1 : Sweep1

design Without One Plane (Q3D Extractor, model units mm)
options: SParamCalcMethod=EqTransLine Calculate_Lossy_Dielectrics
variables:
  hcavity = 15.3mil
  tlayer = 1.3mil
  L = 1600mil
geometry:
  via [copper] = cylinder(axis=Z, base_centre=(0mil, 0mil, 0mil), radius=4mil, height=tlayer+hcavity+tlayer)
  via_1 = via.copy()
  via_5 = via.copy()
  via.move_faces(MoveAlongNormalFlag=true OffsetDistance=39.370079mil FacesToMove=via.face(3 of 3))
  via.move_faces(MoveAlongNormalFlag=true OffsetDistance=39.370079mil FacesToMove=via.face(2 of 3))
  coordinate_system RelativeCS1 = origin=(31.496063mil, 0mil, -94.488189mil) x=(39.370079mil, 0mil, 0mil) y=(0mil, 39.370079mil, 0mil)
  via.move_faces(MoveAlongNormalFlag=true OffsetDistance=-39.370079mil FacesToMove=via.face(3 of 3)) in RelativeCS1
  via.move_faces(MoveAlongNormalFlag=true OffsetDistance=-39.370079mil FacesToMove=via.face(2 of 3)) in RelativeCS1
  top = box(corner=(-L/2, -L/2, 0mil), size=(L, L, tlayer))
  bottom [copper] = top.duplicate_along_line(step=(0mil, 0mil, -17.9mil), total=2)
  top.delete()
  antipad = cylinder(axis=Z, base_centre=(0mil, 0mil, 0mil), radius=15mil, height=tlayer+hcavity+tlayer)
  antipad_2 = antipad.copy()
  bottom.subtract(antipad_2)
  bottom.move(0mil, 0mil, 35.8mil)
  bottom.move(0mil, 0mil, -1.3mil)
  antipad.subtract(via_1)
  antipad_4 = antipad.copy()
  bottom.subtract(antipad_4)
  bottom.subtract(via_5)
  bottom.move_faces(MoveAlongNormalFlag=true OffsetDistance=39.370079mil FacesToMove=bottom.face(#94))
  bottom.move_faces(MoveAlongNormalFlag=true OffsetDistance=-39.370079mil FacesToMove=bottom.face(#94)) in RelativeCS1
  antipad.delete()
  antipad1 [FR4_epoxy_paper] = cylinder(axis=Z, base_centre=(0mil, 0mil, 0mil), radius=15mil, height=tlayer+hcavity+tlayer)
  via1 = cylinder(axis=Z, base_centre=(0mil, 0mil, 0mil), radius=4mil, height=tlayer+hcavity+tlayer)
  via_6 = via1.copy()
  antipad1.subtract(via_6)
  antipad_3 = antipad1.copy()
  via_2 = via1.copy()
  via_3 = via1.copy()
  antipad1.subtract(via_3)
  antipad1.move_faces(MoveAlongNormalFlag=true OffsetDistance=39.370079mil FacesToMove=antipad1.face(3 of 3))
  antipad1.move_faces(MoveAlongNormalFlag=true OffsetDistance=39.370079mil FacesToMove=antipad1.face(2 of 3))
  coordinate_system RelativeCS2 = origin=(31.496063mil, 0mil, -94.488189mil) x=(39.370079mil, 0mil, 0mil) y=(0mil, 39.370079mil, 0mil)
  antipad1.move_faces(MoveAlongNormalFlag=true OffsetDistance=-39.370079mil FacesToMove=antipad1.face(3 of 3)) in RelativeCS2
  antipad1.move_faces(MoveAlongNormalFlag=true OffsetDistance=-39.370079mil FacesToMove=antipad1.face(2 of 3)) in RelativeCS2
  dielectric [FR4_epoxy_paper] = box(corner=(-L/2, -L/2, tlayer), size=(L, L, hcavity))
  dielectric.subtract(via_2)
  dielectric.subtract(antipad_3)
  via_4 = via1.copy()
  dielectric.subtract(via_4)
  via1.delete()
  Region [vacuum] = region(percentage_offset=0 on all sides)
boundaries and excitations:
  Source1: Source Faces=via.face(3 of 3) TerminalType=ConstantVoltage Net=via
  via: SignalNet Objects=via
  bottom: SignalNet Objects=bottom
  Sink1: Sink Faces=via.face(2 of 3) TerminalType=ConstantVoltage Net=via
setups:
  Setup1: Matrix AdaptiveFreq=60GHz Cap{MaxPass=10 MinPass=1 MinConvPass=1 PerError=1 PerRefine=30 AutoIncreaseSolutionOrder SolutionOrder=High Solver_Type=Iterative} DC{Cond{MaxPass=10 MinPass=1 MinConvPass=1 PerError=1 PerRefine=30} Mult{MaxPass=1 MinPass=1 MinConvPass=1 PerError=1 PerRefine=30} Solution_Order=Normal} AC{MaxPass=10 MinPass=1 MinConvPass=1 PerError=1 PerRefine=30} ErrorValue=0.1
    sweep Sweep1: 0GHz to 40MHz step 1MHz; 40MHz to 200GHz step 40MHz; Type=Interpolating InterpTolerance=0.5 InterpMaxSolns=50 MinSolvedFreq=100000
source amplitudes:
  via:Source1: AC 1A
  bottom: Cap 1V 0deg
  via: Cap 0V 0deg
  via:Source1: DC 1A
reports:
  C Matrix Plot 1: -C(via,bottom), C(via,via) vs Freq on Setup1 : Sweep1
  ACL Matrix Plot 1: ACL(via:Source1,via:Source1) vs Freq on Setup1 : Sweep1
  DCL Matrix Plot 1: DCL(via:Source1,via:Source1) vs Freq on Setup1 : Sweep1
   Plot 1: ACL(via:Source1,via:Source1)*freq*2*pi vs Freq on Setup1 : Sweep1
  ACL Matrix Plot 2: ACL(via:Source1,via:Source1) vs Freq on Setup1 : Sweep1

design Double-Sided (HFSS, DrivenTerminal, model units mil)
variables:
  hcavity = 15.3mil
  tlayer = 1.3mil
  L = 1600mil
geometry:
  via = cylinder(axis=Z, base_centre=(0mil, 0mil, 0mil), radius=4mil, height=tlayer+hcavity+tlayer)
  via_1 = via.copy()
  via_5 = via.copy()
  via.move_faces(MoveAlongNormalFlag=true OffsetDistance=39.370079mil FacesToMove=via_7.face(3 of 3))
  via.move_faces(MoveAlongNormalFlag=true OffsetDistance=39.370079mil FacesToMove=via_7.face(2 of 3))
  coordinate_system RelativeCS1 = origin=(31.496063mil, 0mil, -94.488189mil) x=(39.370079mil, 0mil, 0mil) y=(0mil, 39.370079mil, 0mil)
  via.move_faces(MoveAlongNormalFlag=true OffsetDistance=-39.370079mil FacesToMove=via_7.face(3 of 3)) in RelativeCS1
  via.move_faces(MoveAlongNormalFlag=true OffsetDistance=-39.370079mil FacesToMove=via_7.face(2 of 3)) in RelativeCS1
  via.move_faces(MoveAlongNormalFlag=true OffsetDistance=-1.3mil FacesToMove=via_7.face(2 of 3))
  via.move_faces(MoveAlongNormalFlag=true OffsetDistance=39.370079mil FacesToMove=via_7.face(3 of 3))
  via.move_faces(MoveAlongNormalFlag=true OffsetDistance="(-15.3/2) mil" FacesToMove=via_7.face(2 of 3))
  via.move_faces(MoveAlongNormalFlag=true OffsetDistance="(15.3/2) mil" FacesToMove=via_7.face(2 of 3))
  via.move_faces(MoveAlongNormalFlag=true OffsetDistance="(-15.3/2) mil" FacesToMove=via_7.face(2 of 3))
  via.move_faces(MoveAlongNormalFlag=true OffsetDistance="(15.3/2) mil" FacesToMove=via_7.face(2 of 3))
  via.move_faces(MoveAlongNormalFlag=true OffsetDistance="(-15.3/2) mil" FacesToMove=via_7.face(2 of 3))
  via.move_faces(MoveAlongNormalFlag=true OffsetDistance="(15.3/2) mil" FacesToMove=via_7.face(2 of 3))
  via.move_faces(MoveAlongNormalFlag=true OffsetDistance="(-15.3/2) mil" FacesToMove=via_7.face(2 of 3))
  via.move_faces(MoveAlongNormalFlag=true OffsetDistance="(15.3/2) mil" FacesToMove=via_7.face(2 of 3))
  via.move_faces(MoveAlongNormalFlag=true OffsetDistance="(-15.3/2) mil" FacesToMove=via_7.face(2 of 3))
  top = box(corner=(-L/2, -L/2, 0mil), size=(L, L, tlayer))
  top_1 [copper] = top.duplicate_along_line(step=(0mil, 0mil, -17.9mil), total=2)
  top.delete()
  antipad = cylinder(axis=Z, base_centre=(0mil, 0mil, 0mil), radius=15mil, height=tlayer+hcavity+tlayer)
  antipad_2 = antipad.copy()
  top_1.subtract(antipad_2)
  top_1.move(0mil, 0mil, 35.8mil)
  top_1.move(0mil, 0mil, -1.3mil)
  antipad.subtract(via_1)
  antipad_4 = antipad.copy()
  top_1.subtract(antipad_4)
  antipad.delete()
  top_1.subtract(via_5)
  top_1.move_faces(MoveAlongNormalFlag=true OffsetDistance=39.370079mil FacesToMove=top_1.face(#67))
  top_1.move_faces(MoveAlongNormalFlag=true OffsetDistance=-39.370079mil FacesToMove=top_1.face(#67)) in RelativeCS1
  top_1.move_faces(MoveAlongNormalFlag=true OffsetDistance=39.370079mil FacesToMove=top_1.face(#67))
  antipad1 [FR4_epoxy_paper] = cylinder(axis=Z, base_centre=(0mil, 0mil, 0mil), radius=15mil, height=tlayer+hcavity+tlayer)
  via1 = cylinder(axis=Z, base_centre=(0mil, 0mil, 0mil), radius=4mil, height=tlayer+hcavity+tlayer)
  via_6 = via1.copy()
  antipad1.subtract(via_6)
  antipad_3 = antipad1.copy()
  via_2 = via1.copy()
  via_3 = via1.copy()
  antipad1.subtract(via_3)
  antipad1.move_faces(MoveAlongNormalFlag=true OffsetDistance=39.370079mil FacesToMove=antipad1.face(3 of 3))
  antipad1.move_faces(MoveAlongNormalFlag=true OffsetDistance=39.370079mil FacesToMove=antipad1.face(2 of 3))
  coordinate_system RelativeCS2 = origin=(31.496063mil, 0mil, -94.488189mil) x=(39.370079mil, 0mil, 0mil) y=(0mil, 39.370079mil, 0mil)
  antipad1.move_faces(MoveAlongNormalFlag=true OffsetDistance=-39.370079mil FacesToMove=antipad1.face(3 of 3)) in RelativeCS2
  antipad1.move_faces(MoveAlongNormalFlag=true OffsetDistance=-39.370079mil FacesToMove=antipad1.face(2 of 3)) in RelativeCS2
  antipad1.move_faces(MoveAlongNormalFlag=true OffsetDistance=-1.3mil FacesToMove=antipad1.face(2 of 3))
  antipad1.move_faces(MoveAlongNormalFlag=true OffsetDistance=39.370079mil FacesToMove=antipad1.face(3 of 3))
  antipad1.move_faces(MoveAlongNormalFlag=true OffsetDistance="(-15.3/2) mil" FacesToMove=antipad1.face(2 of 3))
  antipad1.move_faces(MoveAlongNormalFlag=true OffsetDistance="(15.3/2) mil" FacesToMove=antipad1.face(2 of 3))
  antipad1.move_faces(MoveAlongNormalFlag=true OffsetDistance="(-15.3/2) mil" FacesToMove=antipad1.face(2 of 3))
  antipad1.move_faces(MoveAlongNormalFlag=true OffsetDistance="(15.3/2) mil" FacesToMove=antipad1.face(2 of 3))
  antipad1.move_faces(MoveAlongNormalFlag=true OffsetDistance="(-15.3/2) mil" FacesToMove=antipad1.face(2 of 3))
  antipad1.move_faces(MoveAlongNormalFlag=true OffsetDistance="(15.3/2) mil" FacesToMove=antipad1.face(2 of 3))
  antipad1.move_faces(MoveAlongNormalFlag=true OffsetDistance="(-15.3/2) mil" FacesToMove=antipad1.face(2 of 3))
  antipad1.move_faces(MoveAlongNormalFlag=true OffsetDistance="(15.3/2) mil" FacesToMove=antipad1.face(2 of 3))
  antipad1.move_faces(MoveAlongNormalFlag=true OffsetDistance="(-15.3/2) mil" FacesToMove=antipad1.face(2 of 3))
  dielectric [FR4_epoxy_paper] = box(corner=(-L/2, -L/2, tlayer), size=(L, L, hcavity))
  dielectric.subtract(via_2)
  dielectric.subtract(antipad_3)
  via_4 = via1.copy()
  dielectric.subtract(via_4)
  via1.delete()
  dielectric.move_faces(MoveAlongNormalFlag=true OffsetDistance="(-15.3/2) mil" FacesToMove=dielectric.face(-z))
  dielectric.move_faces(MoveAlongNormalFlag=true OffsetDistance="(15.3/2) mil" FacesToMove=dielectric.face(-z))
  dielectric.move_faces(MoveAlongNormalFlag=true OffsetDistance="(-15.3/2) mil" FacesToMove=dielectric.face(-z))
  dielectric.move_faces(MoveAlongNormalFlag=true OffsetDistance="(15.3/2) mil" FacesToMove=dielectric.face(-z))
  dielectric.move_faces(MoveAlongNormalFlag=true OffsetDistance="(-15.3/2) mil" FacesToMove=dielectric.face(-z))
  dielectric.move_faces(MoveAlongNormalFlag=true OffsetDistance="(15.3/2) mil" FacesToMove=dielectric.face(-z))
  dielectric.move_faces(MoveAlongNormalFlag=true OffsetDistance="(-15.3/2) mil" FacesToMove=dielectric.face(-z))
  dielectric.move_faces(MoveAlongNormalFlag=true OffsetDistance="(15.3/2) mil" FacesToMove=dielectric.face(-z))
  dielectric.move_faces(MoveAlongNormalFlag=true OffsetDistance="(-15.3/2) mil" FacesToMove=dielectric.face(-z))
  dielectric_1 = dielectric.duplicate_mirror(point=(0mil, 0mil, 8.95mil), normal=(0mil, 0mil, -39.370079mil))
  via_7 [copper] = via.duplicate_mirror(point=(0mil, 0mil, 8.95mil), normal=(0mil, 0mil, -39.370079mil))
  bottom_1 [copper] = top_1.duplicate_mirror(point=(0mil, 0mil, 8.95mil), normal=(0mil, 0mil, -39.370079mil))
  antipad1_1 = antipad1.duplicate_mirror(point=(0mil, 0mil, 8.95mil), normal=(0mil, 0mil, -39.370079mil))
  via_7.unite(via)
  antipad1.unite(antipad1_1)
  dielectric.unite(dielectric_1)
  Rectangle1 = rectangle(corner=(0mil, 0mil, -39.370079mil), x_size=30mil, y_size=30mil)
  Rectangle1_1, Rectangle1_2, Rectangle1_3 = Rectangle1.duplicate_around_axis(axis=Z, angle=90deg, total=4)
  Rectangle1.unite(Rectangle1_1, Rectangle1_2, Rectangle1_3)
  Rectangle2 = rectangle(corner=(0mil, 0mil, 57.270079mil), x_size=30mil, y_size=30mil)
  Rectangle2_1, Rectangle2_2, Rectangle2_3 = Rectangle2.duplicate_around_axis(axis=Z, angle=90deg, total=4)
  Rectangle2.unite(Rectangle2_1, Rectangle2_2, Rectangle2_3)
  Region [vacuum] = region(percentage_offset=0 on all sides)
boundaries and excitations:
  Rad1: Radiation Objects=Region
  via_7_T1: Terminal port=1 Faces=via_7.face(3 of 3) TerminalResistance=50ohm
  via_7_T2: Terminal port=2 Faces=via_7.face(3 of 3) TerminalResistance=50ohm
  1: Wave Port Faces=Rectangle2.face(at (15, 15, 57.2701)) NumModes=1
  2: Wave Port Faces=Rectangle1.face(at (15, 15, -39.3701)) NumModes=1
  reference conductors: bottom_1
setups:
  setup: HfssDriven MultipleAdaptiveFreqsSetup{AdaptAt{Frequency=2.5GHz Delta=0.01} AdaptAt{Frequency=5GHz Delta=0.01} AdaptAt{Frequency=10GHz Delta=0.01} AdaptAt{Frequency=50GHz Delta=0.01} AdaptAt{Frequency=80GHz Delta=0.01}} MaximumPasses=20 MinimumPasses=1 MinimumConvergedPasses=1 PercentRefinement=30 BasisOrder=1 PortAccuracy=2 DrivenSolverType="Direct Solver"
    sweep Sweep1: 40MHz to 100GHz step 40MHz; Type=Interpolating InterpTolerance=0.5 InterpMaxSolns=50 PassivityErrorTolerance=0.0001
source amplitudes:
  1:1: 1V 0deg
  2:1: 0V 0deg
reports:
   Plot 6: 1/(re(Zo(1))*2*pi*freq) vs Freq on setup : Sweep1
   Plot 7: -1/(im(Zt(via_7_T1,via_7_T1))*2*pi*freq) vs Freq on setup : Sweep1
   Plot 8: dB20(Zt(via_7_T1,via_7_T1)) vs Freq on setup : Sweep1
