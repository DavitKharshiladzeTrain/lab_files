# Ansys Electronics Desktop project, version 2022.2
materials:
  vacuum: permittivity=1
  copper: permeability=0.999991 conductivity=58000000
  FR4_epoxy_paper: permittivity=3.68 dielectric_loss_tangent=0.02

design HFSSDesign2 (HFSS, DrivenTerminal, model units mil)
variables:
  L = 360mil
  viaR = 4mil
  antiR = 14mil
  h = 10mil
  viaPitch = 40mil
  t = 1mil
geometry:
  Top [copper] = box(corner=(0mil, 0mil, h), size=(L, L, t))
  Dielectric [FR4_epoxy_paper] = box(corner=(0mil, 0mil, 0mil), size=(L, L, h))
  Via1 [copper] = cylinder(axis=Z, base_centre=(155mil, 155mil, 0mil), radius=viaR, height=h+t)
  Via2 [copper] = Via1.duplicate_along_line(step=(0mil, viaPitch, 0mil), total=2)
  AntiPad1 [FR4_epoxy_paper] = cylinder(axis=Z, base_centre=(155mil, 155mil, 0mil), radius=antiR, height=h+t)
  AntiPad2 = AntiPad1.duplicate_along_line(step=(0mil, viaPitch, 0mil), total=2)
  merged_antipad = box(corner=(155mil-antiR, 155mil, 0mil), size=(2*antiR, viaPitch, h+t))
  AntiPad1_1 = AntiPad1.copy()
  AntiPad2_1 = AntiPad2.copy()
  merged_antipad_1 = merged_antipad.copy()
  Top.subtract(AntiPad1_1, AntiPad2_1, merged_antipad_1)
  Via1_1 = Via1.copy()
  Via2_1 = Via2.copy()
  AntiPad1.subtract(Via1_1, Via2_1)
  Via1_2 = Via1.copy()
  Via2_2 = Via2.copy()
  AntiPad2.subtract(Via1_2, Via2_2)
  Via1_3 = Via1.copy()
  Via2_3 = Via2.copy()
  Dielectric.subtract(Via1_3, Via2_3)
  Via1_4 = Via1.copy()
  Via2_4 = Via2.copy()
  merged_antipad.subtract(Via1_4, Via2_4)
  AntiPad1_2 = AntiPad1.copy()
  AntiPad2_2 = AntiPad2.copy()
  merged_antipad_2 = merged_antipad.copy()
  Dielectric.subtract(AntiPad1_2, AntiPad2_2, merged_antipad_2)
  AntiPad1_3 = AntiPad1.copy()
  AntiPad2_3 = AntiPad2.copy()
  merged_antipad.subtract(AntiPad1_3, AntiPad2_3)
  AntiPad1.unite(AntiPad2, merged_antipad)
  Rectangle1 = rectangle(corner=(155mil-antiR, 155mil-antiR, h+t+1mm), x_size=2*antiR, y_size=2*antiR+viaPitch)
  Via1.move_faces(MoveAlongNormalFlag=true OffsetDistance=39.370079mil FacesToMove=Via1.face(3 of 3))
  AntiPad1.move_faces(MoveAlongNormalFlag=true OffsetDistance=39.370079mil FacesToMove=AntiPad1.face(3 of 3))
  Via2.move_faces(MoveAlongNormalFlag=true OffsetDistance=39.370079mil FacesToMove=Via2.face(3 of 3))
  Top.move_faces(MoveAlongNormalFlag=true OffsetDistance=39.370079mil FacesToMove=Top.face(+z))
  Dielectric.move_faces(MoveAlongNormalFlag=true OffsetDistance=-h/2 FacesToMove=Dielectric.face(-z))
  AntiPad1.move_faces(MoveAlongNormalFlag=true OffsetDistance=-h/2 FacesToMove=AntiPad1.face(2 of 3))
  Via2.move_faces(MoveAlongNormalFlag=true OffsetDistance=-h/2 FacesToMove=Via2.face(2 of 3))
  Via1.move_faces(MoveAlongNormalFlag=true OffsetDistance=-h/2 FacesToMove=Via1.face(2 of 3))
  Dielectric.move_faces(MoveAlongNormalFlag=true OffsetDistance=5mil FacesToMove=Dielectric.face(-z))
  AntiPad1.move_faces(MoveAlongNormalFlag=true OffsetDistance=5mil FacesToMove=AntiPad1.face(2 of 3))
  Via2.move_faces(MoveAlongNormalFlag=true OffsetDistance=5mil FacesToMove=Via2.face(2 of 3))
  Via1.move_faces(MoveAlongNormalFlag=true OffsetDistance=5mil FacesToMove=Via1.face(2 of 3))
  Region [vacuum] = region(absolute_offset=0mil on all sides)
boundaries and excitations:
  PerfH1: Perfect H Faces=Dielectric.face(-z) AntiPad1.face(2 of 3) Via2.face(2 of 3) Via1.face(2 of 3)
  Rad1: Radiation Faces=Top.face(+x, -y, -x, +y, +z) Dielectric.face(+x, -y, -x, +y) AntiPad1.face(3 of 3) Via2.face(3 of 3) Via1.face(3 of 3)
  Via1_T1: Terminal port=1 Faces=Via1.face(3 of 3) TerminalResistance=50ohm
  Via2_T1: Terminal port=1 Faces=Via2.face(3 of 3) TerminalResistance=50ohm
  1: Wave Port Faces=Rectangle1.face NumModes=1 DeembedDist=1mm
  reference conductors: Top
setups:
  Setup1: HfssDriven Frequency=5GHz MaxDeltaS=0.02 MaximumPasses=6 MinimumPasses=1 MinimumConvergedPasses=1 PercentRefinement=30 BasisOrder=1 PortAccuracy=2 DrivenSolverType="Direct Solver"
    sweep Sweep: 0Hz to 60GHz step 500MHz; Type=Interpolating InterpTolerance=0.5 InterpMaxSolns=250 MinSolvedFreq=0.01GHz PassivityErrorTolerance=0.0001
source amplitudes:
  1:1: 1 0deg
  1:2: 0V 0deg
reports:
  Terminal S Parameter Plot 1: dB(St(Via1_T1,Via1_T1)), dB(St(Via1_T1,Via2_T1)) vs Freq on Setup1 : Sweep
  Terminal Z Parameter Plot 1: mag(Zt(Via1_T1,Via1_T1)), mag(Zt(Via1_T1,Via2_T1)) vs Freq on Setup1 : Sweep
  Capacitance(Z(1,1)): -1/im(Zt(Via1_T1,Via1_T1))/2/pi/freq vs Freq on Setup1 : Sweep; markers m2 at 20GHz
