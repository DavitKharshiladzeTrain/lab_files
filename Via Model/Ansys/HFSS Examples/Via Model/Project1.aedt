# Ansys Electronics Desktop project, version 2022.2
materials:
  vacuum: permittivity=1
  Isola FR408HR: permittivity=3.68 dielectric_loss_tangent=0.0092
  copper: permeability=0.999991 conductivity=58000000
  SampleMaterial: permittivity=3.44149+0.0235217*ln((2.53303e+22+Freq*Freq)/(4.95658e+09+Freq*Freq)) conductivity=1e-12+2.61714e-12*Freq*(atan(Freq/70403)-atan(Freq/1.59155e+11))

design HFSSDesign1 (HFSS, DrivenTerminal, model units mil)
variables:
  a = 1600
  h = 15.3
  t = 1.3
  ro = 4
  ra = 15
geometry:
  substrate [SampleMaterial] = box(corner=(-0.5*a mil, -0.5*a mil, -0.5*h mil), size=(a mil, a mil, h mil))
  via [copper] = cylinder(axis=Z, base_centre=(0mil, 0mil, (-0.5*h - t) mil), radius=ro mil, height=(2*t + h) mil)
  Cylinder2_1 = via.copy()
  substrate.subtract(Cylinder2_1)
  Region [vacuum] = region(percentage_offset=0 on all sides)
  top_cond1 = box(corner=(-0.5*a mil, -0.5*a mil, 0.5*h mil), size=(a mil, a mil, t mil))
  bot_cond1 [copper] = top_cond1.duplicate_mirror(point=(0mil, 0mil, 0mil), normal=(0mil, 0mil, -1mil))
  top_cond1.delete()
  Cylinder3 = cylinder(axis=Z, base_centre=(0mil, 0mil, (-0.5*h - t) mil), radius=ra mil, height=(2*t + h) mil)
  Cylinder1_3 = Cylinder3.copy()
  bot_cond1.subtract(Cylinder1_3)
  Cylinder3.delete()
  top_cond2 [copper] = box(corner=(-0.5*a mil, -0.5*a mil, 0.5*h mil), size=(a mil, a mil, t mil))
  Cylinder4 = cylinder(axis=Z, base_centre=(0mil, 0mil, (-0.5*h - t) mil), radius=ra mil, height=(2*t + h) mil)
  Cylinder1_4 = Cylinder4.copy()
  top_cond2.subtract(Cylinder1_4)
  Cylinder4.delete()
  Cylinder5 [SampleMaterial] = cylinder(axis=Z, base_centre=(0mil, 0mil, (h/2) mil), radius=ra mil, height=t mil)
  Cylinder5_1 [SampleMaterial] = Cylinder5.duplicate_mirror(point=(0mil, 0mil, 0mil), normal=(0mil, 0mil, -1mil))
  via_1 = via.copy()
  Cylinder5.subtract(via_1)
  via_2 = via.copy()
  Cylinder5_1.subtract(via_2)
  top_cond2.move_faces(MoveAlongNormalFlag=true OffsetDistance=1mm FacesToMove=top_cond2.face(+z))
  Cylinder5.move_faces(MoveAlongNormalFlag=true OffsetDistance=1mm FacesToMove=Cylinder5.face(3 of 3))
  via.move_faces(MoveAlongNormalFlag=true OffsetDistance=1mm FacesToMove=via.face(3 of 3))
  bot_cond1.move_faces(MoveAlongNormalFlag=true OffsetDistance=1mm FacesToMove=bot_cond1.face(1 of 6))
  Cylinder5_1.move_faces(MoveAlongNormalFlag=true OffsetDistance=1mm FacesToMove=Cylinder5_1.face(3 of 3))
  via.move_faces(MoveAlongNormalFlag=true OffsetDistance=1mm FacesToMove=via.face(2 of 3))
  Rectangle1 = rectangle(corner=(0mil, 0mil, 48.320079mil), x_size=25mil, y_size=25mil)
  Rectangle1_1 = Rectangle1.duplicate_around_axis(axis=Z, angle=180deg, total=2)
  Rectangle1_2 = Rectangle1.duplicate_around_axis(axis=Z, angle=270deg, total=2)
  Rectangle1_3 = Rectangle1.duplicate_around_axis(axis=Z, angle=90deg, total=2)
  Rectangle1.unite(Rectangle1_1, Rectangle1_2, Rectangle1_3)
  Rectangle1_4 = Rectangle1.duplicate_mirror(point=(0mil, 0mil, 0mil), normal=(0mil, 0mil, -1mil))
boundaries and excitations:
  Rad1: Radiation Objects=Region
  via_1: Terminal port=1 Faces=via.face(3 of 3) TerminalResistance=50ohm
  via_2: Terminal port=2 Faces=via.face(2 of 3) TerminalResistance=50ohm
  1: Wave Port Faces=Rectangle1.face(at (12.5, 12.5, 48.3201)) NumModes=1 DeembedDist=1mm
  2: Wave Port Faces=Rectangle1_4.face NumModes=1 DeembedDist=1mm
  reference conductors: bot_cond1
setups:
  Setup1: HfssDriven Frequency=60GHz MaxDeltaS=0.005 MaximumPasses=40 MinimumPasses=1 MinimumConvergedPasses=1 PercentRefinement=30 BasisOrder=1 PortAccuracy=2 DrivenSolverType="Direct Solver"
    sweep Sweep: 40MHz to 100GHz step 0.04GHz; Type=Interpolating InterpTolerance=0.5 InterpMaxSolns=250 PassivityErrorTolerance=0.0001
source amplitudes:
  1:1: 1V 0deg
  2:1: 0V 0deg
reports:
  Terminal S Parameter Plot 1: dB(St(via_1,via_1)) vs Freq on Setup1 : Sweep
  Terminal S Parameter Plot 2: dB(St(via_1,via_2)) vs Freq on Setup1 : Sweep
