# Ansys Electronics Desktop project, version 2022.2
materials:
  vacuum: permittivity=1
  copper: permeability=0.999991 conductivity=58000000
  FR4_epoxy: permittivity=3.74076+0.0255671*ln((2.53303e+22+Freq*Freq)/(4.95658e+09+Freq*Freq)) conductivity=1e-12+2.84472e-12*Freq*(atan(Freq/70403)-atan(Freq/1.59155e+11))
  FR4_new_paper: permittivity=3.44149+0.0235217*ln((2.53303e+22+Freq*Freq)/(4.95658e+09+Freq*Freq)) conductivity=1e-12+2.61714e-12*Freq*(atan(Freq/70403)-atan(Freq/1.59155e+11))
  FR4_freq_dep: permittivity=3.74076+0.0255671*ln((2.53303e+22+Freq*Freq)/(4.95658e+09+Freq*Freq)) conductivity=1e-12+2.84472e-12*Freq*(atan(Freq/70403)-atan(Freq/1.59155e+11))
  gallium_arsenide: permittivity=12.9

design HFSSDesign1 (HFSS, DrivenTerminal, model units mil)
options: Allow_Material_Override Calculate_Lossy_Dielectrics
variables:
  rvia = 4mil
  apad = 4mil
  bantipad = 7mil
  tgnd = 1.3mil
  hudie = 15.3mil
  dk = 3.5
geometry:
  bot [copper] = box(corner=(-1000mil, -1000mil, 0mil), size=(2000mil, 2000mil, tgnd))
  via [copper] = cylinder(axis=Z, base_centre=(0mil, 0mil, 0mil), radius=rvia, height=tgnd*2+hudie)
  top [copper] = bot.duplicate_along_line(step=(0mil, 0mil, tgnd+hudie), total=2)
  Cylinder1 = cylinder(axis=Z, base_centre=(0mil, 0mil, tgnd+hudie), radius=bantipad, height=tgnd)
  Cylinder1_1 = Cylinder1.duplicate_along_line(step=(0mil, 0mil, -tgnd-hudie), total=2)
  Cylinder1_2 = Cylinder1.copy()
  Cylinder1.delete()
  top.subtract(Cylinder1_2)
  bot.subtract(Cylinder1_1)
  die [FR4_new_paper] = box(corner=(-1000mil, -1000mil, 0), size=(2000mil, 2000mil, hudie+tgnd*2))
  Rectangle1 = rectangle(corner=(-19.685039mil, -19.685039mil, -39.370079mil), x_size=39.370079mil, y_size=39.370079mil)
  Rectangle2 = rectangle(corner=(-19.685039mil, -19.685039mil, tgnd*2+hudie+1mm), x_size=39.370079mil, y_size=39.370079mil)
  Region [vacuum] = region(percentage_offset=0 on all sides)
  bot_1 = bot.copy()
  top_1 = top.copy()
  via_1 = via.copy()
  die.subtract(bot_1, top_1, via_1)
  via.move_faces(MoveAlongNormalFlag=true OffsetDistance=39.370079mil FacesToMove=via.face(3 of 3))
  die.move_faces(MoveAlongNormalFlag=true OffsetDistance=39.370079mil FacesToMove=die.face(+z))
  top.move_faces(MoveAlongNormalFlag=true OffsetDistance=39.370079mil FacesToMove=top.face(1 of 6))
  via.move_faces(MoveAlongNormalFlag=true OffsetDistance=39.370079mil FacesToMove=via.face(2 of 3))
  die.move_faces(MoveAlongNormalFlag=true OffsetDistance=39.370079mil FacesToMove=die.face(-z))
  bot.move_faces(MoveAlongNormalFlag=true OffsetDistance=39.370079mil FacesToMove=bot.face(-z))
boundaries and excitations:
  Rad1: Radiation Objects=Region
  via_T1: Terminal port=2 Faces=via.face(2 of 3) TerminalResistance=50ohm
  via_T2: Terminal port=1 Faces=via.face(3 of 3) TerminalResistance=50ohm
  2: Wave Port Faces=Rectangle1.face NumModes=1 DeembedDist=1mm
  1: Wave Port Faces=Rectangle2.face NumModes=1 DeembedDist=1mm
  reference conductors: bot, top
setups:
  Setup1: HfssDriven Frequency=60GHz MaxDeltaS=0.01 MaximumPasses=20 MinimumPasses=4 MinimumConvergedPasses=2 PercentRefinement=30 BasisOrder=1 PortAccuracy=2 DrivenSolverType="Direct Solver"
    sweep Sweep: 40MHz to 100000MHz step 0.04GHz; Type=Interpolating InterpTolerance=0.5 InterpMaxSolns=250 PassivityErrorTolerance=0.0001
source amplitudes:
  2:1: 1V 0deg
  1:1: 0V 0deg
reports:
  Terminal S Parameter Plot 1: dB(St(via_T1,via_T1)) vs Freq on Setup1 : Sweep
  Terminal S Parameter Plot 2: dB(St(via_T2,via_T1)) vs Freq on Setup1 : Sweep; markers m1 at 0.24GHz, m2 at 0.2GHz, m3 at 0.12GHz
  Terminal S Parameter Plot 3: dB(St(via_T2,via_T2)) vs Freq on Setup1 : Sweep
  Terminal S Parameter Plot 4: dB(St(via_T2,via_T1)) vs Freq on Setup1 : Sweep
